* ============================================================
* Bootstrapped sampling switch -- VERSION (b): 6V devices
* CK high = track/ON ; CKB = complement.
* Keeps Vgs(Msw) ~ const over Vin (verified flat to ~2.7% across 0.65-2.65V).
* Peak internal node (ct) reaches ~Vin+VDD = up to 5.23V -> 6V devices required.
* Ports: vin vout ck ckb vdd vss
* ============================================================
.subckt boot_sw_b vin vout ck ckb vdd vss
Cb  cb ct 4p
* charge ct->VDD during hold, gate gp protected (Mpc ties gp->ct in track so Mp1 stays off when ct boosts)
Mp1 ct  gp  vdd vdd pfet_06v0 W=10u L=0.6u
Mnb gp  ckb vss vss nfet_06v0 W=2u  L=0.6u
Mpc gp  ckb ct  ct  pfet_06v0 W=2u  L=0.6u
* hold: cb->0 ; gate ng->0 (switch OFF)
Mn1 cb  ckb vss vss nfet_06v0 W=5u  L=0.6u
Mn2 ng  ckb vss vss nfet_06v0 W=5u  L=0.6u
* track: connect ct->ng (PMOS gate=ckb) and cb->vin (NMOS, bootstrapped gate=ng)
Mp2 ct  ckb ng  ng  pfet_06v0 W=8u  L=0.6u
Mn3 cb  ng  vin vss nfet_06v0 W=10u L=0.6u
* main sampling switch ; Vgs held ~VDD by the boost
Msw vin ng  vout vss nfet_06v0 W=40u L=0.6u
.ends
